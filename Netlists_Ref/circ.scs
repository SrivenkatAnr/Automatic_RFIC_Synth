// PA circuit 1 - Reference

simulator lang=spectre
include "/cad/library/TSMC/65/lp/models/spectre/crn65lp_2d5_lk_v1d7_usage.scs" section=tt_lib

// ------------------------ SETTING PARAMETER VALUES ------------------------------------

// ----- Resistors -----
parameters res_in_len=50
parameters res_in_wid=50
parameters res_bias_len=50
parameters res_bias_wid=50
//parameters res_drain=50
parameters res_load_len=50
parameters res_load_wid=50

// ----- Inductors -----
parameters ind_drain_w=3e-05
parameters ind_drain_rad=9e-05
parameters ind_drain_turn=5.5
parameters ind_drain_gdis=5e-05
parameters ind_drain_spc=4e-06

parameters ind_mn_src_w=3e-05
parameters ind_mn_src_rad=9e-05
parameters ind_mn_src_turn=5.5
parameters ind_mn_src_gdis=5e-05
parameters ind_mn_src_spc=4e-06

parameters ind_mn_load_w=3e-05
parameters ind_mn_load_rad=9e-05
parameters ind_mn_load_turn=5.5
parameters ind_mn_load_gdis=5e-05
parameters ind_mn_load_spc=4e-06

// ----- Capacitors -----
parameters cap_in_len=5e-13
parameters cap_in_wid=2.5e-09
parameters cap_in_mf=2

parameters cap_out_len=5e-13
parameters cap_out_wid=2.5e-09
parameters cap_out_mf=2

parameters cap_mn_len=5e-13
parameters cap_mn_wid=2.5e-09
parameters cap_mn_mf=2

// ----- MOSFETs -----
parameters len=6e-08
parameters wid_bias=8e-05
parameters wid_amp=wid_bias
parameters n_finger=41
parameters multi=1

// ----- Sources -----
parameters cur0=0.003
parameters v_dd=1.0
parameters fund_1=1900000000.0

// ----- Analysis -----
parameters n_harm=5
parameters pin_start=-70
parameters pin_stop=5
parameters pin_step=1
parameters cir_temp=27
parameters pin_sweep=(pin_start+pin_stop)/2

// ------------------------ NETLIST STATEMENTS ------------------------------------

// ----- Resistors -----
Rin (Vin 0 0) rnpolywo_m wr=res_in_wid lr=res_in_len

Rb_p (G1p Vb 0) rnpolywo_m wr=res_bias_wid lr=res_bias_len
Rb_n (G1n Vb 0) rnpolywo_m wr=res_bias_wid lr=res_bias_len

Rl (Vout_p_load Vout_n_load 0) rnpolywo_m wr=res_load_wid lr=res_load_len

// ----- Inductors -----
Ld_p (Vdd D1p_pr 0) spiral_std_mu_z rad=ind_drain_rad w=ind_drain_w nr=ind_drain_turn gdis=ind_drain_gdis spacing=ind_drain_spc
Ld_n (Vdd D1n 0) spiral_std_mu_z rad=ind_drain_rad w=ind_drain_w nr=ind_drain_turn gdis=ind_drain_gdis spacing=ind_drain_spc

Lsrc (Vout_p Vout_pr 0) spiral_std_mu_z rad=ind_mn_src_rad w=ind_mn_src_w nr=ind_mn_src_turn gdis=ind_mn_src_gdis spacing=ind_mn_src_spc
Lload (Vout_p_load Vout_n_load 0) spiral_std_mu_z rad=ind_mn_load_rad w=ind_mn_load_w nr=ind_mn_load_turn gdis=ind_mn_load_gdis spacing=ind_mn_load_spc

// ----- Capacitors -----
C1_p (E1p G1p 0) mimcap_sin_3t wt=cap_in_wid lt=cap_in_len mf=cap_in_mf
C1_n (E1n G1n 0) mimcap_sin_3t wt=cap_in_wid lt=cap_in_len mf=cap_in_mf

C2_p (D1p Vout_p 0) mimcap_sin_3t wt=cap_out_wid lt=cap_out_len mf=cap_out_mf
C2_n (D1n Vout_n 0) mimcap_sin_3t wt=cap_out_wid lt=cap_out_len mf=cap_out_mf

Cmn_p (Vout_p Vout_p_load 0) mimcap_sin_3t wt=cap_mn_wid lt=cap_mn_len mf=cap_mn_mf
Cmn_n (Vout_pr Vout_n_load 0) mimcap_sin_3t wt=cap_mn_wid lt=cap_mn_len mf=cap_mn_mf

// ----- MOSFETs -----
M0 (Vb Vb 0 0) nch w=wid_bias l=len nf=n_finger m=multi

M1 (D1p G1p 0 0) nch w=wid_amp l=len nf=n_finger m=multi
M2 (D1n G1n 0 0) nch w=wid_amp l=len nf=n_finger m=multi

// ----- Sources -----
Vs (Vin 0) port type=sine dbm=pin_sweep freq=fund_1 fundname=fund1 mag=1e-4 r=50 num=1
Io (Vdd Vb) isource dc=cur0
Vpower (Vdd 0) vsource dc=v_dd
buf_p (E1p 0) bsource v=v(Vin,0)
buf_n (E1n 0) bsource v=v(0,Vin)

Settings options rawfmt=psfascii temp=cir_temp

// ------------------------ ANALYSIS STATEMENTS ------------------------------------
dc_test dc oppoint=logfile

ac_test ac start=fund_1 stop=2*fund_1 dec=1

ip_load (Vout_pr Vout_n) iprobe
ip_drain (D1p_pr D1p) iprobe

//gcomp_test hb xdbcompression="yes" xdblevel=1 xdbgain="power" xdbsource=Vs xdbload=Rl xdbharm=[1] xdbstart=pin_start xdbmax=20 fundfreqs=[fund_1] maxharms=[n_harm] save="all"

tran_test tran start=0s stop=20n skipdc=yes

swp sweep param=pin_sweep start=pin_start stop=pin_stop step=pin_step {
phdev_test hb fundfreqs=[fund_1] maxharms=[n_harm] save="all"
}
// ------------------------ PRINT STATEMENTS ------------------------------------
print V(Vout_p)-V(Vout_n), I(Vpower), V(Vs), I(Vs), V(G1p), V(D1p), M1:ids, M1:gm, M1:gds, M1:vth, M1:vds, M1:vdsat, M1:cgs, M1:cgd, M1:region, V(Vpower), I(ip_drain), name=dc_test to="dc.out"

print re(V(Vout_p)-V(Vout_n)), im(V(Vout_p)-V(Vout_n)), re(V(Vin)), im(V(Vin)), mag(V(Vout_p)-V(Vout_n))/mag(V(Vin)), mag((V(Vout_p)-V(Vout_n))/I(ip_load)), mag(V(Vin)/I(Vs)), name=ac_test to="ac.out"
