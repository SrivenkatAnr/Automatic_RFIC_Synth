// PA circuit 1 - Reference

simulator lang=spectre
include "/cad/library/TSMC/65/lp/models/spectre/crn65lp_2d5_lk_v1d7_usage.scs" section=tt_lib

// ------------------------ SETTING PARAMETER VALUES ------------------------------------

// ----- Resistors -----
parameters res_in=50
parameters res_drain=3.01592894745
parameters res_bias=1000
parameters res_load=20

// ----- Inductors -----
parameters ind_drain=1.2e-08
parameters ind_mn_src=1.2e-08
parameters ind_mn_load=1.2e-08

// ----- Capacitors -----
parameters cap_coup_in=5e-13
parameters cap_coup_out=2.5e-09
parameters cap_mn=2.5e-09

// ----- MOSFETs -----
parameters len=6e-08
parameters wid_bias=8e-05
parameters wid_amp=wid_bias
parameters n_finger=41
parameters multi=1

// ----- Sources -----
parameters cur0=0.003
parameters v_dd=1.0
parameters fund_1=1900000000.0

// ----- Analysis -----
parameters n_harm=5
parameters pin_start=-70
parameters pin_stop=5
parameters pin_step=1
parameters cir_temp=27
parameters pin_sweep=(pin_start+pin_stop)/2

// ------------------------ NETLIST STATEMENTS ------------------------------------

// ----- Resistors -----
Rin (Vin 0) resistor r=res_in

Rd_p (T1p D1p_pr) resistor r=res_drain
Rd_n (T1n D1n) resistor r=res_drain

Rb_p (G1p Vb) resistor r=res_bias
Rb_n (G1n Vb) resistor r=res_bias

//Rl (Vout_p Vout_pr) resistor r=res_load
Rl (Vout_p_load Vout_n_load) resistor r=res_load
//Rl_p (Vout_p_load 0) resistor r=50
//Rl_n (Vout_n_load 0) resistor r=50

// ----- Inductors -----
Ld_p (Vdd T1p) inductor l=ind_drain
Ld_n (Vdd T1n) inductor l=ind_drain

Lsrc (Vout_p Vout_pr) inductor l=ind_mn_src
Lload (Vout_p_load Vout_n_load) inductor l=ind_mn_load

// ----- Capacitors -----
C1_p (E1p G1p) capacitor c=cap_coup_in
C1_n (E1n G1n) capacitor c=cap_coup_in

C2_p (D1p Vout_p) capacitor c=cap_coup_out
C2_n (D1n Vout_n) capacitor c=cap_coup_out

Cmn_p (Vout_p Vout_p_load) capacitor c=cap_mn
Cmn_n (Vout_pr Vout_n_load) capacitor c=cap_mn

// ----- MOSFETs -----
M0 (Vb Vb 0 0) nch w=wid_bias l=len nf=n_finger m=multi

M1 (D1p G1p 0 0) nch w=wid_amp l=len nf=n_finger m=multi
M2 (D1n G1n 0 0) nch w=wid_amp l=len nf=n_finger m=multi

// ----- Sources -----
Vs (Vin 0) port type=sine dbm=pin_sweep freq=fund_1 fundname=fund1 mag=1e-4 r=50 num=1
Io (Vdd Vb) isource dc=cur0
Vpower (Vdd 0) vsource dc=v_dd
buf_p (E1p 0) bsource v=v(Vin,0)
buf_n (E1n 0) bsource v=v(0,Vin)

Settings options rawfmt=psfascii temp=cir_temp

// ------------------------ ANALYSIS STATEMENTS ------------------------------------
dc_test dc oppoint=logfile

ac_test ac start=fund_1 stop=2*fund_1 dec=1

ip_load (Vout_pr Vout_n) iprobe
ip_drain (D1p_pr D1p) iprobe

gcomp_test hb xdbcompression="yes" xdblevel=1 xdbgain="power" xdbsource=Vs xdbload=Rl xdbharm=[1] xdbstart=pin_start xdbmax=20 fundfreqs=[fund_1] maxharms=[n_harm] save="all"

tran_test tran start=0s stop=20n skipdc=yes

swp sweep param=pin_sweep start=pin_start stop=pin_stop step=pin_step {
phdev_test hb fundfreqs=[fund_1] maxharms=[n_harm] save="all"
}
// ------------------------ PRINT STATEMENTS ------------------------------------
print V(Vout_p)-V(Vout_n), I(Vpower), V(Vs), I(Vs), V(G1p), V(D1p), M1:ids, M1:gm, M1:gds, M1:vth, M1:vds, M1:vdsat, M1:cgs, M1:cgd, M1:region, V(Vpower), I(ip_drain), name=dc_test to="dc.out"

print re(V(Vout_p)-V(Vout_n)), im(V(Vout_p)-V(Vout_n)), re(V(Vin)), im(V(Vin)), mag(V(Vout_p)-V(Vout_n))/mag(V(Vin)), mag((V(Vout_p)-V(Vout_n))/I(ip_load)), mag(V(Vin)/I(Vs)), name=ac_test to="ac.out"
