// PA circuit 1 - Reference

simulator lang=spectre
include "/cad/library/TSMC/65/lp/models/spectre/crn65lp_2d5_lk_v1d7_usage.scs" section=tt_lib

// ------------------------ SETTING PARAMETER VALUES ------------------------------------

// ----- Resistors -----
parameters res_in=50
parameters res_drain=0.2
parameters res_bias=20000
parameters res_load=20

// ----- Inductors -----
parameters ind_drain=1e-08

// ----- Capacitors -----
parameters cap_coup_in=5e-13
parameters cap_coup_out=2.5e-09

// ----- MOSFETs -----
parameters len=6e-08
parameters wid_bias=0.0009
parameters wid_amp=wid_bias
parameters n_finger=451

// ----- Sources -----
parameters cur0=0.000171
parameters v_dd=1.0
parameters fund_1=999000000.0
parameters fund_2=1000000000.0
parameters pin=-65

// ----- Analysis -----
parameters n_harm=5
parameters pin_start=-70
parameters pin_stop=-40
parameters n_pin=120
parameters cir_temp=27

// ------------------------ NETLIST STATEMENTS ------------------------------------

// ----- Resistors -----
Rin (Vin 0) resistor r=res_in
Rd (T1 D1) resistor r=res_drain
Rbias (G1 Vb) resistor r=res_bias
Rl (Vout 0) resistor r=res_load

// ----- Inductors -----
Ld (Vdd T1) inductor l=ind_drain

// ----- Capacitors -----
Ccoup_in (E1 G1) capacitor c=cap_coup_in
Ccoup_out (D1 Vout) capacitor c=cap_coup_out

// ----- MOSFETs -----
M0 (Vb Vb 0 0) nch w=wid_bias l=len nf=n_finger
M1 (D1 G1 0 0) nch w=wid_amp l=len nf=n_finger

// ----- Sources -----
Vs (Vin 0) port type=sine dbm=pin freq=fund_1 fundname=fund1 dbm2=pin freq2=fund_2 fundname2=fund2 mag=1 r=50 num=1
Io (Vdd Vb) isource dc=cur0
Vpower (Vdd 0) vsource dc=v_dd
buf (E1 0) bsource v=v(Vin,0)

Settings options rawfmt=psfascii temp=cir_temp

// ------------------------ ANALYSIS STATEMENTS ------------------------------------
dc_test dc oppoint=logfile
ac_test ac start=fund_1 stop=2*fund_1 dec=1
sp_test sp start=fund_1 stop=2*fund_1 dec=1 donoise=yes oprobe=Rd iprobe=Vs file="sp.out" datatype="dbphase"
noise_test Vout Vdd noise start=fund_1 stop=2*fund_1 dec=1 iprobe=Vs

// ------------------------ PRINT STATEMENTS ------------------------------------
print V(Vout), I(Vpower), V(G1), V(D1), M1:ids, M1:gm, M1:gds, M1:vth, M1:vds, M1:vdsat, M1:cgs, M1:cgd, M1:region, name=dc_test to="dc.out"
print re(V(Vout)), im(V(Vout)), re(V(Vin)), im(V(Vin)),mag(V(Vout))/mag(V(Vin)), name=ac_test to="ac.out"
print noise_test:NF, name=noise_test to="noise.out"
