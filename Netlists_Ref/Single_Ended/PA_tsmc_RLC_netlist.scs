// PA circuit 1 - Reference

simulator lang=spectre
include "/cad/library/TSMC/65/lp/models/spectre/crn65lp_2d5_lk_v1d7_usage.scs" section=tt_lib

// ------------------------ SETTING PARAMETER VALUES ------------------------------------

// ----- Resistors -----
parameters res_in_len=50
parameters res_in_wid=50
parameters res_bias_len=50
parameters res_bias_wid=50
//parameters res_drain=50
parameters res_load_len=50
parameters res_load_wid=50

// ----- Inductors -----
parameters ind_w=3e-05
parameters ind_rad=9e-05
parameters ind_turn=5.5
parameters ind_gdis=5e-05
parameters ind_spc=4e-06

// ----- Capacitors -----
parameters cap_in_len=5e-13
parameters cap_in_wid=2.5e-09
parameters cap_in_mf=2
parameters cap_out_len=5e-13
parameters cap_out_wid=2.5e-09
parameters cap_out_mf=2

// ----- MOSFETs -----
parameters len=6e-08
parameters wid_bias=8e-05
parameters wid_amp=wid_bias
parameters n_finger=41
parameters multi=1

// ----- Sources -----
parameters cur0=0.003
parameters v_dd=1.0
parameters fund_1=1900000000.0

// ----- Analysis -----
parameters n_harm=5
parameters pin_start=-70
parameters pin_stop=5
parameters pin_step=1
parameters cir_temp=27
parameters pin_sweep=(pin_start+pin_stop)/2

// ------------------------ NETLIST STATEMENTS ------------------------------------

// ----- Resistors -----
Rin (Vin 0 0) rnpolywo_m wr=res_in_wid lr=res_in_len
Rb (G1 Vb 0) rnpolywo_m wr=res_bias_wid lr=res_bias_len
Rl (Vout_p 0 0) rnpolywo_m wr=res_load_wid lr=res_load_len

// ----- Inductors -----
Ld (Vdd D1_p 0) spiral_std_mu_z rad=ind_rad w=ind_w nr=ind_turn gdis=ind_gdis spacing=ind_spc

// ----- Capacitors -----
C1 (E1 G1 0) mimcap_sin_3t wt=cap_in_wid lt=cap_in_len mf=cap_in_mf
C2 (D1 Vout 0) mimcap_sin_3t wt=cap_out_wid lt=cap_out_len mf=cap_out_mf

// ----- MOSFETs -----
M0 (Vb Vb 0 0) nch w=wid_bias l=len nf=n_finger m=multi
M1 (D1 G1 0 0) nch w=wid_amp l=len nf=n_finger m=multi

// ----- Sources -----
Vs (Vin 0) port type=sine dbm=pin_sweep freq=fund_1 fundname=fund1 mag=1e-4 r=50 num=1
Io (Vdd Vb) isource dc=cur0
Vpower (Vdd 0) vsource dc=v_dd
buf (E1 0) bsource v=v(Vin,0)

Settings options rawfmt=psfascii temp=cir_temp

// ------------------------ ANALYSIS STATEMENTS ------------------------------------
dc_test dc oppoint=logfile

ac_test ac start=fund_1 stop=2*fund_1 dec=1

ip_load (Vout Vout_p) iprobe
ip_drain (D1_p D1) iprobe

//gcomp_test hb xdbcompression="yes" xdblevel=1 xdbgain="power" xdbsource=Vs xdbload=Rl xdbharm=[1] xdbstart=pin_start xdbmax=20 fundfreqs=[fund_1] maxharms=[n_harm] save="all"

tran_test tran start=0s stop=20n skipdc=yes

swp sweep param=pin_sweep start=pin_start stop=pin_stop step=pin_step {
phdev_test hb fundfreqs=[fund_1] maxharms=[n_harm] save="all"
}
// ------------------------ PRINT STATEMENTS ------------------------------------
print V(Vout), I(Vpower), V(Vs), I(Vs), V(G1), V(D1), M1:ids, M1:gm, M1:gds, M1:vth, M1:vds, M1:vdsat, M1:cgs, M1:cgd, M1:region, V(Vpower), I(ip_drain), name=dc_test to="dc.out"

print re(V(Vout)), im(V(Vout)), re(V(Vin)), im(V(Vin)), mag(V(Vout))/mag(V(Vin)), mag(V(Vout)/I(ip_load)), mag(V(Vin)/I(Vs)), name=ac_test to="ac.out"
